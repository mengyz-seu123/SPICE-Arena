.subckt OTA VDD GND VINP VINN VOUT IBIAS
XP1 N1 VINP NT VDD sky130_fd_pr__pfet_01v8 W=8 L=1 M=2
XP2 VOUT VINN NT VDD sky130_fd_pr__pfet_01v8 W=8 L=1 M=2
XPT NT IBIAS VDD VDD sky130_fd_pr__pfet_01v8 W=8 L=1 M=2
XPR IBIAS IBIAS VDD VDD sky130_fd_pr__pfet_01v8 W=8 L=1 M=1
R1 N1 GND 10k
R2 VOUT GND 10k
.ends OTA
