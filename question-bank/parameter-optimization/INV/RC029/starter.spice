.subckt DUT IN OUT VDD VSS
XP0 N1 IN VDD VDD sky130_fd_pr__pfet_01v8 W=1 L=0.15 M=1
XN0 N1 IN VSS VSS sky130_fd_pr__nfet_01v8 W=0.5 L=0.15 M=1
XP1 N2 N1 VDD VDD sky130_fd_pr__pfet_01v8 W=4 L=0.15 M=1
XN1 N2 N1 VSS VSS sky130_fd_pr__nfet_01v8 W=2 L=0.15 M=1
XP2 OUT N2 VDD VDD sky130_fd_pr__pfet_01v8 W=32 L=0.15 M=1
XN2 OUT N2 VSS VSS sky130_fd_pr__nfet_01v8 W=16 L=0.15 M=1
.ends DUT
