.subckt DUT IN OUT VDD VSS
XP0 N1 IN VDD VDD sky130_fd_pr__pfet_01v8 W=4 L=0.15 M=1
XN0 N1 IN VSS VSS sky130_fd_pr__nfet_01v8 W=2 L=0.15 M=1
XP1 OUT N1 VDD VDD sky130_fd_pr__pfet_01v8 W=16 L=0.15 M=1
XN1 OUT N1 VSS VSS sky130_fd_pr__nfet_01v8 W=8 L=0.15 M=1
.ends DUT
