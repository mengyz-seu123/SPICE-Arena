.subckt DUT IN OUT VDD VSS
XP0 OUT IN VDD VDD sky130_fd_pr__pfet_01v8 W=1.2 L=0.15 M=1
XN0 OUT IN VSS VSS sky130_fd_pr__nfet_01v8 W=4 L=0.15 M=1
.ends DUT
