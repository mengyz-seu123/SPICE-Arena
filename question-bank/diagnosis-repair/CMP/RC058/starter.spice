.subckt DUT VDD VSS VINP VINN VOUT
XIP N1 VINP NT VSS sky130_fd_pr__nfet_01v8 W=8 L=0.5 M=1
XIN N2 VINN NT VSS sky130_fd_pr__nfet_01v8 W=8 L=0.5 M=1
XLP N1 N1 VDD VDD sky130_fd_pr__pfet_01v8 W=6 L=0.5 M=2
XLN N2 N1 VDD VDD sky130_fd_pr__pfet_01v8 W=6 L=0.5 M=2
RB VDD NB 100k
XREF NB NB VSS VSS sky130_fd_pr__nfet_01v8 W=2 L=1 M=1
XTAIL NT NB VSS VSS sky130_fd_pr__nfet_01v8 W=4 L=1 M=1
XBP VOUT VDD VDD VDD sky130_fd_pr__pfet_01v8 W=8 L=0.15 M=1
XBN VOUT VDD VSS VSS sky130_fd_pr__nfet_01v8 W=4 L=0.15 M=1
.ends DUT
