.subckt INV A Y VDD VSS
XN Y A VSS VSS sky130_fd_pr__nfet_01v8 W=0.84 L=0.15 M=1
XP Y A VDD VDD sky130_fd_pr__pfet_01v8 W=1.68 L=0.15 M=1
.ends INV
.subckt DUT VDD VSS OUT
X1 OUT N1 VDD VSS INV
X2 N1 N2 VDD VSS INV
X3 N2 N3 VDD VSS INV
X4 N3 N4 VDD VSS INV
X5 N4 OUT VDD VSS INV
C1 N1 VSS 10f
C2 N2 VSS 10f
C3 N3 VSS 10f
C4 N4 VSS 10f
.ends DUT
