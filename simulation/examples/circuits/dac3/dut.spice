.subckt INV A Y VDD VSS
XN Y A VSS VSS sky130_fd_pr__nfet_01v8 W=0.84 L=0.15 M=1
XP Y A VDD VDD sky130_fd_pr__pfet_01v8 W=1.68 L=0.15 M=1
.ends INV
.subckt TG A Y EN ENB VDD VSS
XN A EN Y VSS sky130_fd_pr__nfet_01v8 W=1.26 L=0.15 M=1
XP A ENB Y VDD sky130_fd_pr__pfet_01v8 W=2.52 L=0.15 M=1
.ends TG
.subckt DUT VDD VSS B0 B1 B2 VREF VOUT
XIB0 B0 B0B VDD VSS INV
XIB1 B1 B1B VDD VSS INV
XIB2 B2 B2B VDD VSS INV
XT0H VREF N0 B0 B0B VDD VSS TG
XT0L VSS N0 B0B B0 VDD VSS TG
XT1H VREF N1 B1 B1B VDD VSS TG
XT1L VSS N1 B1B B1 VDD VSS TG
XT2H VREF N2 B2 B2B VDD VSS TG
XT2L VSS N2 B2B B2 VDD VSS TG
RLSB N0 VOUT 40k
RMID N1 VOUT 20k
RMSB N2 VOUT 10k
RLEAK VOUT VSS 10Meg
.ends DUT
