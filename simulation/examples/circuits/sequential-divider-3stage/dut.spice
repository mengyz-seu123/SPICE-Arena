.subckt INV A Y VDD VSS
XN Y A VSS VSS sky130_fd_pr__nfet_01v8 W=0.84 L=0.15 M=1
XP Y A VDD VDD sky130_fd_pr__pfet_01v8 W=1.68 L=0.15 M=1
.ends INV
.subckt TG A Y EN ENB VDD VSS
XN A EN Y VSS sky130_fd_pr__nfet_01v8 W=1.26 L=0.15 M=1
XP A ENB Y VDD sky130_fd_pr__pfet_01v8 W=2.52 L=0.15 M=1
.ends TG
.subckt DFF D CLK Q QB VDD VSS
XCLKINV CLK CLKB VDD VSS INV
XMIN D M CLKB CLK VDD VSS TG
XMFB MQ M CLK CLKB VDD VSS TG
XMINV1 M MB VDD VSS INV
XMINV2 MB MQ VDD VSS INV
XSIN MQ S CLK CLKB VDD VSS TG
XSFB Q S CLKB CLK VDD VSS TG
XSINV1 S SB VDD VSS INV
XSINV2 SB Q VDD VSS INV
XQBINV Q QB VDD VSS INV
CM M VSS 2f
CS S VSS 2f
.ends DFF
.subckt DUT VDD VSS CLK Q1 Q2 Q3
XFF1 Q1B CLK Q1 Q1B VDD VSS DFF
XFF2 Q2B Q1 Q2 Q2B VDD VSS DFF
XFF3 Q3B Q2 Q3 Q3B VDD VSS DFF
.ends DUT
